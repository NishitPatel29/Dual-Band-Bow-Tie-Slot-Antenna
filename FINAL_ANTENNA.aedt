# Ansys Electronics Desktop project, version 2023.2
materials:
  vacuum: permittivity=1
  air: permittivity=1.0006 permeability=1.0000004
  copper: permeability=0.999991 conductivity=58000000
  Teflon (tm): permittivity=2.1 dielectric_loss_tangent=0.001
  Taconic RF-35 (tm): permittivity=3.5 dielectric_loss_tangent=0.0018

design HFSSDesign2 (HFSS, HFSS Modal Network, model units mm)
variables:
  r_inner = 0.8mm
  r_diel = 3.1mm
  r_outer = 4mm
geometry:
  Box3 [Taconic RF-35 (tm)] = box(corner=(0mm, 0mm, 0mm), size=(34mm, 73mm, 0.8mm))
  point Point1 = (17mm, 36.5mm, 0.8mm)
  point Point2 = (17mm, 33.5mm, 0mm)
  point Point3 = (17mm, 39.5mm, 0mm)
  Box3.rotate(axis=Y, angle=180deg)
  Box3.rotate(axis=Z, angle=180deg)
  Box3.move(0mm, 73mm, 0mm)
  point Point4 = (16.7mm, 38.5mm, 0mm)
  outer [copper] = cylinder(axis=X, base_centre=(34mm, 38.5mm, 0mm), radius=r_outer, height=7mm)
  dielectric [Teflon (tm)] = cylinder(axis=X, base_centre=(34mm, 38.5mm, 0mm), radius=r_diel, height=7mm)
  inner [copper] = cylinder(axis=X, base_centre=(30mm, 38.5mm, 0mm), radius=r_inner, height=11mm)
  dielectric1 = cylinder(axis=X, base_centre=(34mm, 38.5mm, 0mm), radius=r_diel, height=7mm)
  outer.subtract(dielectric1)
  inner1 = cylinder(axis=X, base_centre=(31mm, 38.5mm, 0mm), radius=r_inner, height=10mm)
  dielectric.subtract(inner1)
  [inner, outer, dielectric].move(-18mm, 0mm, 0.64mm)
  [outer, inner, dielectric].move(18mm, -38mm, 0mm)
  Rectangle4 [vacuum] = imported_body()
  [outer, inner, dielectric].move(0mm, 38mm, 0mm)
  RadiatingSurface [vacuum] = region(absolute_offset: +X=0mm, -X=22.727273mm, +Y=22.727273mm, -Y=22.727273mm, +Z=22.727273mm, -Z=22.727273mm)
  inner.move(0mm, 0mm, 0mm)
  outer.move(0mm, 0mm, 0mm)
  dielectric.move(0mm, 0mm, 0mm)
  [inner, outer, dielectric].move(0mm, 0mm, 0mm)
  [inner, outer, dielectric].move(0mm, 0mm, 0.8mm)
  [inner, outer, dielectric].move(0mm, 0mm, -0.64mm)
  [inner, outer, dielectric].move(0mm, 0mm, -0.1mm)
  [inner, outer, dielectric].move(0mm, 0mm, 0.1mm)
boundaries and excitations:
  PerfE1: Perfect E Objects=Rectangle4
  Open1: Radiation Objects=RadiatingSurface
  1: Lumped Port Faces=inner.face(+x end) dielectric.face(+x end) LumpedPortType=Modal Modes{Mode1{IntLine{(41, 38.5, 0.8) -> (41, 38.5, 3.9)} CharImp=Zpi RenormImp=50ohm}} Impedance=50ohm
setups:
  Setup1: HfssDriven MultipleAdaptiveFreqsSetup{Low=2GHz High=11GHz} MaxDeltaS=0.02 MaximumPasses=6 MinimumPasses=1 MinimumConvergedPasses=1 PercentRefinement=30 BasisOrder=1 PortAccuracy=2 DrivenSolverType="Direct Solver"
    sweep Sweep: 2GHz to 11GHz, 900 points; Type=Fast SaveFields
source amplitudes:
  1:1: 1W 0deg
radiation setups:
  3D: Infinite Sphere Theta=0deg..360deg step 30deg Phi=0deg..90deg step 3deg
  Elevation: Infinite Sphere Theta=-180deg..180deg step 1deg Phi=0deg..90deg step 90deg
  Azimuth: Infinite Sphere Theta=90deg..90deg step 0deg Phi=-180deg..180deg step 1deg
  cutplane: Infinite Sphere Theta=0deg..360deg step 3deg Phi=0deg..90deg step 90deg
field plots:
  4p7: Jsurf over Rectangle4.face(all 3) on Setup1 : Sweep at Freq=4.703GHz Phase=0deg
  Vector_Jsurf1, Vector_Jsurf2: Jsurf over Rectangle4.face(all 3) outer.face(all 4) inner.face(all 3) on Setup1 : Sweep at Freq=4.703GHz Phase=0deg
reports:
  S Parameter Plot 1: dB(S(1,1)) vs Freq on Setup1 : Sweep [r_diel=3.1mm r_outer=4mm]; markers m1 at 4.8231368GHz, m2 at 5.894327GHz, m3 at 8.0667408GHz, MY1 at y=-10
  Gain Plot 1: dB(GainPhi), dB(GainTheta) vs Theta on Setup1 : Sweep, cutplane [Phi=all Freq=4.703GHz r_diel=3.1mm r_outer=4mm]
  S Parameter Plot 2: dB(S(1,1)) vs Freq on Setup1 : Sweep; markers m1 at 4.8331479GHz, m2 at 5.9243604GHz, m3 at 8.0667408GHz, MY1 at y=-30
  Gain Plot 2: dB(GainPhi), dB(GainTheta) vs Theta on Setup1 : Sweep, cutplane [Phi=all Freq=4.703GHz r_diel=3.1mm r_outer=4mm]
  Gain Plot 3: dB(GainPhi), dB(GainTheta) vs Theta on Setup1 : Sweep, cutplane [Phi=all Freq=5.80423GHz r_diel=3.1mm r_outer=4mm]
  Gain Plot 4: dB(GainPhi), dB(GainTheta) vs Theta on Setup1 : Sweep, cutplane [Phi=all Freq=10.0089GHz r_diel=3.1mm r_outer=4mm]
